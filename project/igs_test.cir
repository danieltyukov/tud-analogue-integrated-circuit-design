* IGS - find operating point with new optimized values
.lib et4252_hspice.sp

VDD vdd 0 1.8
Id mirror 0 293u

M1 vout gate 0 0 nch W=94.76u L=0.2u ad=60.6p as=60.6p pd=96.04u ps=96.04u
M2 vout mirror vdd vdd pch W=179.92u L=0.9u ad=115.1p as=115.1p pd=181.2u ps=181.2u
M3 mirror mirror vdd vdd pch W=179.92u L=0.9u ad=115.1p as=115.1p pd=181.2u ps=181.2u

CL vout 0 940f

* Sweep Vgate to find where Id(M1) = Id(M2)
Vgate gate 0 0.56
.op
.end
